| IBIS/IBIS-AMI Models for Agilex 5 Device GPIO by Altera Corporation
| This is a pre-synthesis generated IBIS
| The Compiler has not performed Pin assignment legality checks.
| After finalizing your design with complete I/O assignments and
| successfully running the Fitter, regenerate the IBIS file to ensure
| the most accurate models for your board design.
| The command used to generate the output ibs file is present in
| axe5000_top_axe5000_top_a5ec008bm16ae6s_early.log.
[IBIS ver]   6.1
[File name]  axe5000_top_axe5000_top_a5ec008bm16ae6s_early.ibs
[File Rev]   1.2 Mar 2025
[Date]   12 Nov 2025
[Source]   Altera Corporation
[Notes]   Refer Agilex_5_GPIO_IBIS_Models_User_Guide & Agilex_5_HPS_SDM_IBIS_Model_User_Guide
   for the models naming nomenclature.
[Disclaimer] This IBIS model is provided in connection with Intel products. No
             license, express or implied, by estoppel or otherwise, to any
             intellectual property rights is granted by this document. Except
             as provided in Intel's Terms and Conditions of Sale for such
             products, Intel assumes no liability whatsoever, and Intel
             disclaims any express or implied warranty, relating to sale
             and/or use of Intel products including liability or warranties
             relating to fitness for a particular purpose, merchantability, or
             infringement of any patent, copyright or other intellectual
             property right. The IBIS model may be used to create end products
             used in safety-critical applications designed to comply with
             functional safety standards or requirements
             ("safety-critical applications"). It is your responsibility to
             design, manage and assure system-level safeguards to anticipate,
             monitor and control system failures, and you agree that you are
             solely responsible for all applicable regulatory standards and
             safety-related requirements concerning your use of the IBIS
             model in safety critical applications. You agree to indemnify and
             hold Intel and its representatives harmless against any damages,
             costs, and expenses arising in any way out of your use of the
             IBIS model in safety-critical applications.
[Copyright]  Copyright (C) 2025 Altera Corporation. All rights reserved.
|   Component Agilex_5_Device_GPIO
[Component]  Agilex5_A5EC008BM16AE6S
[Manufacturer] Altera Corporation
[Package]
| variable   typ   min   max
R_pkg   1101.34m   479.77m   2219.9m
L_pkg   3.33nH   1.57nH   6.37nH
C_pkg   1.69pF   1.02pF   2.68pF
[Pin] signal_name   model_name   R_pin   L_pin   C_pin
A10   GND   GND
A11   NC   NC   1372.03m  4.0677nH   1.91999pF
A12   USER_BTN   lv12_in_wpu   930.396m  2.88063nH  1.51487pF
A13   NC   NC   681.66m   2.20019nH  1.25979pF
A14   NC   NC   662.489m  2.13428nH  1.24806pF
A15   GND   GND
A16   NC   NC
A17   NC   NC
A18   NC   NC
A19   NC   NC
A2   GND   GND
A20   GND   GND
A21   NC   NC
A22   NC   NC
A23   NC   NC
A24   NC   NC
A25   GND   GND
A26   NC   NC
A27   NC   NC
A28   GND   GND
A29   GND   GND
A3   GND   GND
A4   NC   NC   1282.38m  3.91824nH  1.78484pF
A5   GND   GND
A6   NC   NC   1137.04m  3.39074nH  1.62455pF
A7   CLK_25M_C   lv12_in   835.302m  2.59128nH  1.35263pF
A8   NC   NC   1675.83m  4.80288nH  2.18504pF
A9   NC   NC   1465.27m  4.3239nH   2.02191pF
AA1   NC   NC   2205.06m  6.37159nH  2.67928pF
AA10  VCCP   POWER
AA11  GND   GND
AA12  VCCP   POWER
AA13  GND   GND
AA14  VCCP   POWER
AA15  GND   GND
AA16  VCCL_SDM   POWER
AA17  GND   GND
AA18  VCCL_SDM   POWER
AA19  GND   GND
AA2   NC   NC   1861.48m  5.25905nH  2.30078pF
AA20  VCCFUSEWR_SDM   POWER
AA21  GND   GND
AA22  GND   GND
AA23  GND   GND
AA24  GND   GND
AA25  GND   GND
AA26  GND   GND
AA27  NC   NC
AA28  GND   GND
AA29  GND   GND
AA3   NC   NC   1457.02m  4.27053nH  1.95115pF
AA30  GND   GND
AA4   NC   NC   1535.54m  4.48078nH  2.00525pF
AA5   GND   GND
AA6   NC   NC   1216.96m  3.55768nH  1.68709pF
AA7   NC   NC   1233.47m  3.60041nH  1.73802pF
AA8   VCCPT_HVIO   POWER
AA9   GND   GND
AB1   NC   NC   1904.38m  5.37827nH  2.31328pF
AB10  GND   GND
AB11  VCCP   POWER
AB12  GND   GND
AB13  VCCP   POWER
AB14  GND   GND
AB15  VCCP   POWER
AB16  GND   GND
AB17  VCCPLL_SDM   POWER
AB18  GND   GND
AB19  VCCADC   POWER
AB2   GND   GND
AB20  GND   GND
AB21  VCCIO_HVIO_5B   POWER
AB22  GND   GND
AB23  GND   GND
AB24  NC   NC
AB25  GND   GND
AB26  GND   GND
AB27  GND   GND
AB28  GND   GND
AB29  NC   NC
AB3   NC   NC   1524.87m  4.42877nH  1.98294pF
AB30  NC   NC
AB4   NC   NC   1673.96m  4.80775nH  2.1401pF
AB5   NC   NC   982.278m  2.80959nH  1.47033pF
AB6   NC   NC   1001.62m  2.86527nH  1.49135pF
AB7   GND   GND
AB8   GND   GND
AB9   VCCPT_HVIO   POWER
AC1   NC   NC   1645.21m  4.64877nH  2.0679pF
AC10  NC   NC
AC11  GND   GND
AC12  VCCIO_PIO_2A_T   POWER
AC13  GND   GND
AC14  VCCIO_PIO_2A_B   POWER
AC15  GND   GND
AC16  VCCPLLDIG_SDM   POWER
AC17  GND   GND
AC18  VCCBAT   POWER
AC19  GND   GND
AC2   NC   NC   1632.83m  4.64694nH  2.0912pF
AC20  VCCH_SDM   POWER
AC21  VCCIO_HVIO_5B   POWER
AC22  GND   GND
AC23  NC   NC
AC24  GND   GND
AC25  NC   NC
AC26  GND   GND
AC27  NC   NC
AC28  GND   GND
AC29  GND   GND
AC3   NC   NC   1651.22m  4.77273nH  2.15648pF
AC30  GND   GND
AC4   GND   GND
AC5   NC   NC   857.395m  2.50023nH  1.36122pF
AC6   NC   NC   883.367m  2.56102nH  1.37267pF
AC7   NC   NC   795.368m  2.36221nH  1.29832pF
AC8   NC   NC
AC9   GND   GND
AD1   GND   GND
AD10  GND   GND
AD11  VCCIO_PIO_2A_T   POWER
AD12  GND   GND
AD13  VCCIO_PIO_2A_B   POWER
AD14  GND   GND
AD15  VCCIO_SDM   POWER
AD16  GND   GND
AD17  VCCL_ADC_SDM   POWER
AD18  GND   GND
AD19  VCCIO_PIO_SDM   POWER
AD2   NC   NC   1650.94m  4.7316nH   2.09123pF
AD20  GND   GND
AD21  GND   GND
AD22  VCCIO_HVIO_5A   POWER
AD23  GND   GND
AD24  VCCPT_HVIO   POWER
AD25  GND   GND
AD26  GND   GND
AD27  NC   NC
AD28  GND   GND
AD29  NC   NC
AD3   NC   NC   1230.79m  3.53909nH  1.69185pF
AD30  NC   NC
AD4   NC   NC   1233.39m  3.60708nH  1.70205pF
AD5   NC   NC   1167.77m  3.31397nH  1.62964pF
AD6   GND   GND
AD7   NC   NC   763.562m  2.29047nH  1.28181pF
AD8   GND   GND
AD9   NC   NC
AE1   NC   NC   1623.78m  4.65769nH  2.09562pF
AE10  NC   NC   1676.01m  4.74729nH  2.09117pF
AE11  GND   GND
AE12  NC   NC
AE13  GND   GND
AE14  NC   NC
AE15  GND   GND
AE16  NC   NC   494.566m  1.56834nH  1.02264pF
AE17  NC   NC   842.528m  2.55905nH  1.3263pF
AE18  NC   NC
AE19  GND   GND
AE2   NC   NC   1511.76m  4.40834nH  2.02646pF
AE20  VCC_IO_SDM   POWER
AE21  VCCIO_HVIO_5A   POWER
AE22  GND   GND
AE23  VCCPT_HVIO   POWER
AE24  GND   GND
AE25  NC   NC   697.873m  2.27127nH  1.44895pF
AE26  GND   GND
AE27  GND   GND
AE28  GND   GND
AE29  GND   GND
AE3   GND   GND
AE30  GND   GND
AE4   NC   NC   1068.14m  3.17728nH  1.59024pF
AE5   NC   NC   1131.85m  3.21943nH  1.62449pF
AE6   NC   NC   1030.07m  3.06823nH  1.57482pF
AE7   NC   NC   955.9m   2.81011nH  1.47439pF
AE8   GND   GND
AE9   GND   GND
AF1   NC   NC   1495.58m  4.37667nH  1.96915pF
AF10  GND   GND
AF11  NC   NC   840.263m  2.54338nH  1.33891pF
AF12  NC   NC   1060.17m  3.13413nH  1.58975pF
AF13  NC   NC   1008.71m  2.98123nH  1.53619pF
AF14  NC   NC   885.101m  2.67581nH  1.40944pF
AF15  GND   GND
AF16  NC   NC   748.922m  2.23884nH  1.28554pF
AF17  NC   NC   516.301m  1.68719nH  1.05221pF
AF18  NC   NC
AF19  NC   NC   719.597m  2.61443nH  1.54743pF
AF2   NC   NC   1359.53m  3.97782nH  1.87085pF
AF20  GND   GND
AF21  NC   NC   555.317m  2.03181nH  1.41707pF
AF22  NC   NC   606.402m  2.11063nH  1.39622pF
AF23  NC   NC   602.04m   2.11871nH  1.38967pF
AF24  NC   NC   514.502m  1.86971nH  1.32758pF
AF25  GND   GND
AF26  NC   NC   639.336m  2.12019nH  1.44743pF
AF27  NC   NC   893.445m  2.9802nH   1.88025pF
AF28  GND   GND
AF29  NC   NC
AF3   NC   NC   1105.15m  3.28007nH  1.61176pF
AF30  NC   NC
AF4   NC   NC   1094.5m   3.2178nH   1.56388pF
AF5   GND   GND
AF6   NC   NC   1056.32m  3.09058nH  1.59114pF
AF7   NC   NC   990.479m  2.85963nH  1.50531pF
AF8   NC   NC
AF9   NC   NC   1094.88m  3.25042nH  1.65819pF
AG1   NC   NC   1357.86m  3.95072nH  1.84458pF
AG10  NC   NC   925.984m  2.80598nH  1.46341pF
AG11  NC   NC   1099.08m  3.28091nH  1.63724pF
AG12  GND   GND
AG13  NC   NC   979.382m  2.95474nH  1.52163pF
AG14  NC   NC   926.477m  2.81201nH  1.48129pF
AG15  NC   NC   518.46m   1.66223nH  1.09486pF
AG16  NC   NC   561.87m   1.78679nH  1.1107pF
AG17  GND   GND
AG18  NC   NC
AG19  NC   NC   687.8m   2.49616nH  1.5988pF
AG2   GND   GND
AG20  NC   NC   668.651m  2.41368nH  1.59533pF
AG21  LED1   lv33_in   692.173m  2.50236nH  1.72716pF
AG22  GND   GND
AG23  NC   NC   807.869m  2.80069nH  1.77937pF
AG24  UART_TX   lv33_in   678.277m  2.41964nH  1.50494pF
AG25  GND   GND
AG26  NC   NC   685.944m  2.25713nH  1.48916pF
AG27  GND   GND
AG28  GND   GND
AG29  GND   GND
AG3   NC   NC   1595.34m  4.5483nH   2.03747pF
AG30  GND   GND
AG4   NC   NC   1062.64m  3.14114nH  1.57881pF
AG5   NC   NC   1013.12m  2.96561nH  1.52058pF
AG6   NC   NC   886.698m  2.69588nH  1.41796pF
AG7   GND   GND
AG8   NC   NC
AG9   NC   NC   865.434m  2.66225nH  1.41126pF
AH1   GND   GND
AH10  NC   NC   1243.84m  3.5137nH   1.83282pF
AH11  NC   NC   1232.95m  3.48829nH  1.7534pF
AH12  NC   NC   1149.17m  3.23452nH  1.63154pF
AH13  GND   GND
AH14  GND   GND
AH15  GND   GND
AH16  NC   NC   650.402m  2.28165nH  1.54273pF
AH17  NC   NC   633.596m  2.24462nH  1.52099pF
AH18  NC   NC   952.026m  3.36707nH  2.0112pF
AH19  GND   GND
AH2   NC   NC   1610.77m  4.58398nH  2.0447pF
AH20  NC   NC   882.813m  3.14464nH  2.06235pF
AH21  NC   NC   1050.17m  3.65818nH  2.27607pF
AH22  NC   NC   888.628m  3.10786nH  1.97742pF
AH23  NC   NC   784.946m  2.80382nH  1.85806pF
AH24  GND   GND
AH25  NC   NC   682.533m  2.21358nH  1.49353pF
AH26  NC   NC   772.626m  2.48487nH  1.53896pF
AH27  NC   NC   873.41m   2.81646nH  1.78375pF
AH28  NC   NC   865.169m  2.81035nH  1.78244pF
AH29  GND   GND
AH3   NC   NC   1468.46m  4.19308nH  1.93608pF
AH30  GND   GND
AH4   GND   GND
AH5   NC   NC   1038.06m  3.0253nH   1.53929pF
AH6   NC   NC   912.516m  2.73221nH  1.42076pF
AH7   NC   NC
AH8   NC   NC
AH9   GND   GND
AJ1   GND   GND
AJ10  NC   NC   1178.82m  3.3315nH   1.72054pF
AJ11  GND   GND
AJ12  NC   NC
AJ13  GND   GND
AJ14  NC   NC   1185.01m  3.447nH   1.66293pF
AJ15  NC   NC   1092.13m  3.19792nH  1.59099pF
AJ16  GND   GND
AJ17  NC   NC
AJ18  NC   NC
AJ19  NC   NC   1004.86m  3.56999nH  2.28237pF
AJ2   NC   NC
AJ20  NC   NC   1001.99m  3.48855nH  2.18556pF
AJ21  GND   GND
AJ22  NC   NC   808.539m  2.85397nH  1.8906pF
AJ23  NC   NC   994.791m  3.51521nH  2.18918pF
AJ24  NC   NC   854.989m  3.03004nH  2.00939pF
AJ25  NC   NC   770.877m  2.51823nH  1.57669pF
AJ26  GND   GND
AJ27  NC   NC   786.782m  2.6451nH   1.67938pF
AJ28  NC   NC   984.086m  3.18111nH  1.98588pF
AJ29  NC   NC   843.964m  2.83216nH  1.78069pF
AJ3   NC   NC   1505.05m  4.26874nH  1.96612pF
AJ30  GND   GND
AJ4   NC   NC   1226.02m  3.54778nH  1.73448pF
AJ5   NC   NC   1330.03m  3.90384nH  1.81068pF
AJ6   GND   GND
AJ7   NC   NC   1030.12m  3.11124nH  1.59955pF
AJ8   NC   NC   1000.59m  3.02885nH  1.551pF
AJ9   NC   NC   1206.25m  3.45889nH  1.84195pF
AK10  NC   NC   1113.38m  3.2331nH   1.72727pF
AK11  NC   NC
AK12  NC   NC   2214.79m  6.19544nH  2.60729pF
AK13  GND   GND
AK14  NC   NC   1176.44m  3.45974nH  1.66516pF
AK15  NC   NC   1161.22m  3.43659nH  1.62878pF
AK16  NC   NC   891.053m  2.68116nH  1.38452pF
AK17  NC   NC   801.263m  2.42355nH  1.33004pF
AK18  GND   GND
AK19  NC   NC   1217.44m  4.05549nH  2.44429pF
AK2   GND   GND
AK20  NC   NC   1344.45m  4.68264nH  2.68232pF
AK21  NC   NC   1322.06m  4.43725nH  2.60451pF
AK22  NC   NC   1006.92m  3.34063nH  2.12819pF
AK23  GND   GND
AK24  NC   NC   790.531m  2.69537nH  1.69965pF
AK25  NC   NC   887.347m  2.93262nH  1.73395pF
AK26  NC   NC   962.992m  3.12687nH  1.95877pF
AK27  NC   NC   978.939m  3.26807nH  2.0636pF
AK28  GND   GND
AK29  GND   GND
AK3   GND   GND
AK4   NC   NC   1268.19m  3.63901nH  1.7505pF
AK5   NC   NC   1305.8m   3.89387nH  1.806pF
AK6   NC   NC   1058.37m  3.23288nH  1.54912pF
AK7   NC   NC   1028.03m  3.13487nH  1.53472pF
AK8   GND   GND
AK9   NC   NC   1345.35m  3.85076nH  1.90918pF
B1   GND   GND
B10   NC   NC   1407.26m  4.1504nH   1.93458pF
B11   NC   NC   942.01m   2.86607nH  1.49322pF
B12   GND   GND
B13   NC   NC   698.778m  2.18295nH  1.24133pF
B14   NC   NC   676.936m  2.12416nH  1.22536pF
B15   NC   NC
B16   NC   NC
B17   GND   GND
B18   NC   NC
B19   NC   NC
B2   GND   GND
B20   NC   NC
B21   NC   NC
B22   GND   GND
B23   NC   NC
B24   NC   NC
B25   NC   NC
B26   NC   NC
B27   GND   GND
B28   NC   NC
B29   NC   NC
B3   NC   NC   1442.6m   4.33317nH  1.93458pF
B30   GND   GND
B4   NC   NC   1305.94m  4.02343nH  1.83694pF
B5   NC   NC   1112.17m  3.33091nH  1.64497pF
B6   NC   NC   808.01m   2.51928nH  1.35123pF
B7   GND   GND
B8   NC   NC   1655.43m  4.70499nH  2.17779pF
B9   NC   NC   1444.75m  4.26262nH  1.99011pF
C1   GND   GND
C10   NC   NC   1159.08m  3.39239nH  1.71672pF
C11   NC   NC   963.948m  2.87743nH  1.5341pF
C12   NC   NC   692.056m  2.15605nH  1.25775pF
C13   NC   NC   480.884m  1.57277nH  1.04288pF
C14   GND   GND
C15   NC   NC   479.774m  1.57521nH  1.04248pF
C16   NC   NC
C17   NC   NC
C18   NC   NC
C19   GND   GND
C2   NC   NC   1590.04m  4.6473nH   2.09417pF
C20   NC   NC
C21   NC   NC
C22   NC   NC
C23   NC   NC
C24   GND   GND
C25   NC   NC
C26   NC   NC
C27   NC   NC
C28   GND   GND
C29   GND   GND
C3   NC   NC   1471.23m  4.41917nH  1.94612pF
C30   GND   GND
C4   GND   GND
C5   NC   NC   979.845m  2.88091nH  1.48962pF
C6   NC   NC   953.97m   2.95196nH  1.46902pF
C7   NC   NC   967.681m  3.00322nH  1.45086pF
C8   NC   NC   1372.51m  4.03184nH  1.90389pF
C9   GND   GND
D1   GND   GND
D10   NC   NC   1170.36m  3.4136nH   1.68727pF
D11   GND   GND
D12   NC   NC   992.788m  2.93406nH  1.49972pF
D13   NC   NC   717.399m  2.26013nH  1.22616pF
D14   NC   NC   493.028m  1.61242nH  1.02416pF
D15   NC   NC   504.216m  1.64904nH  1.02664pF
D16   GND   GND
D17   NC   NC
D18   NC   NC
D19   NC   NC
D2   NC   NC   995.228m  3.04623nH  1.54188pF
D20   NC   NC
D21   GND   GND
D22   NC   NC
D23   NC   NC
D24   NC   NC
D25   NC   NC
D26   GND   GND
D27   NC   NC
D28   GND   GND
D29   NC   NC   NA   NA   NA
D3   NC   NC   1565.77m  4.60661nH  2.07168pF
D30   NC   NC   NA   NA   NA
D4   NC   NC   958.678m  2.86423nH  1.46507pF
D5   NC   NC   1155.2m   3.40457nH  1.68403pF
D6   GND   GND
D7   NC   NC   776.547m  2.39029nH  1.30923pF
D8   NC   NC   770.195m  2.36893nH  1.29043pF
D9   NC   NC   1329.21m  3.93604nH  1.89302pF
E1   NC   NC   1097.27m  3.26737nH  1.62728pF
E10   NC   NC   1130.4m   3.40499nH  1.69942pF
E11   NC   NC   936.466m  2.79628nH  1.44148pF
E12   NC   NC   932.811m  2.79669nH  1.44985pF
E13   GND   GND
E14   NC   NC   862.572m  2.60189nH  1.3645pF
E15   NC   NC   843.437m  2.60394nH  1.35556pF
E16   NC   NC
E17   NC   NC
E18   GND   GND
E19   NC   NC
E2   NC   NC   971.378m  3.00263nH  1.53679pF
E20   NC   NC
E21   NC   NC
E22   NC   NC
E23   GND   GND
E24   NC   NC
E25   NC   NC
E26   GND   GND
E27   GND   GND
E28   GND   GND
E29   GND   GND
E3   GND   GND
E30   GND   GND
E4   NC   NC   1308.85m  4.01619nH  1.86587pF
E5   NC   NC   1132.09m  3.36683nH  1.67076pF
E6   NC   NC   1367.92m  4.08651nH  1.92148pF
E7   NC   NC   819.813m  2.54308nH  1.30703pF
E8   GND   GND
E9   NC   NC   1138.43m  3.43211nH  1.69222pF
F1   NC   NC   1064.86m  3.24899nH  1.62532pF
F10   GND   GND
F11   NC   NC   941.187m  2.82304nH  1.48028pF
F12   GND   GND
F13   NC   NC   965.732m  2.85254nH  1.46606pF
F14   GND   GND
F15   GND   GND
F16   GND   GND
F17   GND   GND
F18   GND   GND
F19   GND   GND
F2   NC   NC   1122.91m  3.30052nH  1.64111pF
F20   GND   GND
F21   GND   GND
F22   GND   GND
F23   NC   NC
F24   NC   NC
F25   GND   GND
F26   GND   GND
F27   NC   NC   NA   NA   NA
F28   GND   GND
F29   NC   NC   NA   NA   NA
F3   NC   NC   1478.22m  4.45965nH  2.09354pF
F30   NC   NC   NA   NA   NA
F4   NC   NC   1334.67m  4.04993nH  1.87474pF
F5   GND   GND
F6   NC   NC   1396.85m  4.13998nH  1.90053pF
F7   NC   NC   829.468m  2.55994nH  1.36116pF
F8   GND   GND
F9   NC   NC
G1   NC   NC   1099.21m  3.29402nH  1.62641pF
G10   NC   NC
G11   GND   GND
G12   VCCIO_PIO_3A_T   POWER
G13   GND   GND
G14   VCCIO_PIO_3A_B   POWER
G15   GND   GND
G16   GND   GND
G17   GND   GND
G18   GND   GND
G19   GND   GND
G2   GND   GND
G20   GND   GND
G21   GND   GND
G22   GND   GND
G23   GND   GND
G24   GND   GND
G25   GND   GND
G26   GND   GND
G27   NC   NC   NA   NA   NA
G28   GND   GND
G29   GND   GND
G3   NC   NC   1509.46m  4.51863nH  2.08944pF
G30   GND   GND
G4   NC   NC   876.1m   2.70624nH  1.43129pF
G5   NC   NC   866.928m  2.67071nH  1.37677pF
G6   NC   NC   882.497m  2.7152nH   1.38971pF
G7   GND   GND
G8   NC   NC
G9   GND   GND
H1   NC   NC   1164.79m  3.47788nH  1.72443pF
H10   GND   GND
H11   VCCIO_PIO_3A_T   POWER
H12   GND   GND
H13   VCCIO_PIO_3A_B   POWER
H14   GND   GND
H15   GND   GND
H16   GND   GND
H17   GND   GND
H18   GND   GND
H19   GND   GND
H2   NC   NC   1199.2m   3.53774nH  1.72332pF
H20   GND   GND
H21   GND   GND
H22   GND   GND
H23   GND   GND
H24   NC   NC
H25   NC   NC
H26   GND   GND
H27   GND   GND
H28   GND   GND
H29   NC   NC   NA   NA   NA
H3   NC   NC   895.645m  2.71662nH  1.43846pF
H30   NC   NC   NA   NA   NA
H4   GND   GND
H5   NC   NC   879.59m   2.6747nH   1.43488pF
H6   NC   NC   928.066m  2.84348nH  1.46315pF
H7   NC   NC   948.51m   2.86266nH  1.48122pF
H8   GND   GND
H9   VCCPT_HVIO   POWER
J1   GND   GND
J10   VCCP   POWER
J11   GND   GND
J12   VCCP   POWER
J13   GND   GND
J14   VCCP   POWER
J15   GND   GND
J16   GND   GND
J17   GND   GND
J18   GND   GND
J19   GND   GND
J2   NC   NC   1615.19m  4.82869nH  2.16613pF
J20   GND   GND
J21   GND   GND
J22   GND   GND
J23   GND   GND
J24   GND   GND
J25   GND   GND
J26   GND   GND
J27   NC   NC   NA   NA   NA
J28   GND   GND
J29   GND   GND
J3   NC   NC   972.721m  2.9462nH   1.50035pF
J30   GND   GND
J4   NC   NC   1002.82m  2.97472nH  1.51146pF
J5   NC   NC   906.8m   2.73776nH  1.45873pF
J6   GND   GND
J7   NC   NC   702.12m   2.23532nH  1.23377pF
J8   VCCPT_HVIO   POWER
J9   GND   GND
K1   NC   NC   1073.24m  3.2961nH   1.64959pF
K10   GND   GND
K11   VCCP   POWER
K12   GND   GND
K13   VCCP   POWER
K14   GND   GND
K15   VCCP   POWER
K16   GND   GND
K17   GND   GND
K18   GND   GND
K19   GND   GND
K2   NC   NC   1611.99m  4.82244nH  2.19049pF
K20   GND   GND
K21   GND   GND
K22   GND   GND
K23   GND   GND
K24   NC   NC   542.981m  1.92401nH  1.26158pF
K25   NC   NC   512.225m  1.80685nH  1.24256pF
K26   GND   GND
K27   NC   NC   NA   NA   NA
K28   GND   GND
K29   NC   NC   NA   NA   NA
K3   GND   GND
K30   NC   NC   NA   NA   NA
K4   NC   NC   1123.65m  3.43035nH  1.69902pF
K5   NC   NC   1159.08m  3.50498nH  1.71531pF
K6   NC   NC   1120.09m  3.40311nH  1.66293pF
K7   NC   NC   690.875m  2.17855nH  1.23967pF
K8   GND   GND
K9   NC   NC
L1   NC   NC   1179.55m  3.609nH   1.75972pF
L10   VCCPT   POWER
L11   GND   GND
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[Pin Mapping]  pulldown_ref   pullup_ref   gnd_clamp_ref   power_clamp_ref  ext_ref
A10   GND   NC
A11   NC   NC
A12   GND   VCCIO_PIO_3A_B
A13   NC   NC
A14   NC   NC
A15   GND   NC
A16   NC   NC
A17   NC   NC
A18   NC   NC
A19   NC   NC
A2   GND   NC
A20   GND   NC
A21   NC   NC
A22   NC   NC
A23   NC   NC
A24   NC   NC
A25   GND   NC
A26   NC   NC
A27   NC   NC
A28   GND   NC
A29   GND   NC
A3   GND   NC
A4   NC   NC
A5   GND   NC
A6   NC   NC
A7   GND   VCCIO_PIO_3A_B
A8   NC   NC
A9   NC   NC
AA1   NC   NC
AA10   NC   VCCP
AA11   GND   NC
AA12   NC   VCCP
AA13   GND   NC
AA14   NC   VCCP
AA15   GND   NC
AA16   NC   VCCL_SDM
AA17   GND   NC
AA18   NC   VCCL_SDM
AA19   GND   NC
AA2   NC   NC
AA20   NC   VCCFUSEWR_SDM
AA21   GND   NC
AA22   GND   NC
AA23   GND   NC
AA24   GND   NC
AA25   GND   NC
AA26   GND   NC
AA27   NC   NC
AA28   GND   NC
AA29   GND   NC
AA3   NC   NC
AA30   GND   NC
AA4   NC   NC
AA5   GND   NC
AA6   NC   NC
AA7   NC   NC
AA8   NC   VCCPT_HVIO
AA9   GND   NC
AB1   NC   NC
AB10   GND   NC
AB11   NC   VCCP
AB12   GND   NC
AB13   NC   VCCP
AB14   GND   NC
AB15   NC   VCCP
AB16   GND   NC
AB17   NC   VCCPLL_SDM
AB18   GND   NC
AB19   NC   VCCADC
AB2   GND   NC
AB20   GND   NC
AB21   NC   VCCIO_HVIO_5B
AB22   GND   NC
AB23   GND   NC
AB24   NC   NC
AB25   GND   NC
AB26   GND   NC
AB27   GND   NC
AB28   GND   NC
AB29   NC   NC
AB3   NC   NC
AB30   NC   NC
AB4   NC   NC
AB5   NC   NC
AB6   NC   NC
AB7   GND   NC
AB8   GND   NC
AB9   NC   VCCPT_HVIO
AC1   NC   NC
AC10   NC   NC
AC11   GND   NC
AC12   NC   VCCIO_PIO_2A_T
AC13   GND   NC
AC14   NC   VCCIO_PIO_2A_B
AC15   GND   NC
AC16   NC   VCCPLLDIG_SDM
AC17   GND   NC
AC18   NC   VCCBAT
AC19   GND   NC
AC2   NC   NC
AC20   NC   VCCH_SDM
AC21   NC   VCCIO_HVIO_5B
AC22   GND   NC
AC23   NC   NC
AC24   GND   NC
AC25   NC   NC
AC26   GND   NC
AC27   NC   NC
AC28   GND   NC
AC29   GND   NC
AC3   NC   NC
AC30   GND   NC
AC4   GND   NC
AC5   NC   NC
AC6   NC   NC
AC7   NC   NC
AC8   NC   NC
AC9   GND   NC
AD1   GND   NC
AD10   GND   NC
AD11   NC   VCCIO_PIO_2A_T
AD12   GND   NC
AD13   NC   VCCIO_PIO_2A_B
AD14   GND   NC
AD15   NC   VCCIO_SDM
AD16   GND   NC
AD17   NC   VCCL_ADC_SDM
AD18   GND   NC
AD19   NC   VCCIO_PIO_SDM
AD2   NC   NC
AD20   GND   NC
AD21   GND   NC
AD22   NC   VCCIO_HVIO_5A
AD23   GND   NC
AD24   NC   VCCPT_HVIO
AD25   GND   NC
AD26   GND   NC
AD27   NC   NC
AD28   GND   NC
AD29   NC   NC
AD3   NC   NC
AD30   NC   NC
AD4   NC   NC
AD5   NC   NC
AD6   GND   NC
AD7   NC   NC
AD8   GND   NC
AD9   NC   NC
AE1   NC   NC
AE10   NC   NC
AE11   GND   NC
AE12   NC   NC
AE13   GND   NC
AE14   NC   NC
AE15   GND   NC
AE16   NC   NC
AE17   NC   NC
AE18   NC   NC
AE19   GND   NC
AE2   NC   NC
AE20   NC   VCC_IO_SDM
AE21   NC   VCCIO_HVIO_5A
AE22   GND   NC
AE23   NC   VCCPT_HVIO
AE24   GND   NC
AE25   NC   NC
AE26   GND   NC
AE27   GND   NC
AE28   GND   NC
AE29   GND   NC
AE3   GND   NC
AE30   GND   NC
AE4   NC   NC
AE5   NC   NC
AE6   NC   NC
AE7   NC   NC
AE8   GND   NC
AE9   GND   NC
AF1   NC   NC
AF10   GND   NC
AF11   NC   NC
AF12   NC   NC
AF13   NC   NC
AF14   NC   NC
AF15   GND   NC
AF16   NC   NC
AF17   NC   NC
AF18   NC   NC
AF19   NC   NC
AF2   NC   NC
AF20   GND   NC
AF21   NC   NC
AF22   NC   NC
AF23   NC   NC
AF24   NC   NC
AF25   GND   NC
AF26   NC   NC
AF27   NC   NC
AF28   GND   NC
AF29   NC   NC
AF3   NC   NC
AF30   NC   NC
AF4   NC   NC
AF5   GND   NC
AF6   NC   NC
AF7   NC   NC
AF8   NC   NC
AF9   NC   NC
AG1   NC   NC
AG10   NC   NC
AG11   NC   NC
AG12   GND   NC
AG13   NC   NC
AG14   NC   NC
AG15   NC   NC
AG16   NC   NC
AG17   GND   NC
AG18   NC   NC
AG19   NC   NC
AG2   GND   NC
AG20   NC   NC
AG21   GND   VCCIO_HVIO_5A
AG22   GND   NC
AG23   NC   NC
AG24   GND   VCCIO_HVIO_5A
AG25   GND   NC
AG26   NC   NC
AG27   GND   NC
AG28   GND   NC
AG29   GND   NC
AG3   NC   NC
AG30   GND   NC
AG4   NC   NC
AG5   NC   NC
AG6   NC   NC
AG7   GND   NC
AG8   NC   NC
AG9   NC   NC
AH1   GND   NC
AH10   NC   NC
AH11   NC   NC
AH12   NC   NC
AH13   GND   NC
AH14   GND   NC
AH15   GND   NC
AH16   NC   NC
AH17   NC   NC
AH18   NC   NC
AH19   GND   NC
AH2   NC   NC
AH20   NC   NC
AH21   NC   NC
AH22   NC   NC
AH23   NC   NC
AH24   GND   NC
AH25   NC   NC
AH26   NC   NC
AH27   NC   NC
AH28   NC   NC
AH29   GND   NC
AH3   NC   NC
AH30   GND   NC
AH4   GND   NC
AH5   NC   NC
AH6   NC   NC
AH7   NC   NC
AH8   NC   NC
AH9   GND   NC
AJ1   GND   NC
AJ10   NC   NC
AJ11   GND   NC
AJ12   NC   NC
AJ13   GND   NC
AJ14   NC   NC
AJ15   NC   NC
AJ16   GND   NC
AJ17   NC   NC
AJ18   NC   NC
AJ19   NC   NC
AJ2   NC   NC
AJ20   NC   NC
AJ21   GND   NC
AJ22   NC   NC
AJ23   NC   NC
AJ24   NC   NC
AJ25   NC   NC
AJ26   GND   NC
AJ27   NC   NC
AJ28   NC   NC
AJ29   NC   NC
AJ3   NC   NC
AJ30   GND   NC
AJ4   NC   NC
AJ5   NC   NC
AJ6   GND   NC
AJ7   NC   NC
AJ8   NC   NC
AJ9   NC   NC
AK10   NC   NC
AK11   NC   NC
AK12   NC   NC
AK13   GND   NC
AK14   NC   NC
AK15   NC   NC
AK16   NC   NC
AK17   NC   NC
AK18   GND   NC
AK19   NC   NC
AK2   GND   NC
AK20   NC   NC
AK21   NC   NC
AK22   NC   NC
AK23   GND   NC
AK24   NC   NC
AK25   NC   NC
AK26   NC   NC
AK27   NC   NC
AK28   GND   NC
AK29   GND   NC
AK3   GND   NC
AK4   NC   NC
AK5   NC   NC
AK6   NC   NC
AK7   NC   NC
AK8   GND   NC
AK9   NC   NC
B1   GND   NC
B10   NC   NC
B11   NC   NC
B12   GND   NC
B13   NC   NC
B14   NC   NC
B15   NC   NC
B16   NC   NC
B17   GND   NC
B18   NC   NC
B19   NC   NC
B2   GND   NC
B20   NC   NC
B21   NC   NC
B22   GND   NC
B23   NC   NC
B24   NC   NC
B25   NC   NC
B26   NC   NC
B27   GND   NC
B28   NC   NC
B29   NC   NC
B3   NC   NC
B30   GND   NC
B4   NC   NC
B5   NC   NC
B6   NC   NC
B7   GND   NC
B8   NC   NC
B9   NC   NC
C1   GND   NC
C10   NC   NC
C11   NC   NC
C12   NC   NC
C13   NC   NC
C14   GND   NC
C15   NC   NC
C16   NC   NC
C17   NC   NC
C18   NC   NC
C19   GND   NC
C2   NC   NC
C20   NC   NC
C21   NC   NC
C22   NC   NC
C23   NC   NC
C24   GND   NC
C25   NC   NC
C26   NC   NC
C27   NC   NC
C28   GND   NC
C29   GND   NC
C3   NC   NC
C30   GND   NC
C4   GND   NC
C5   NC   NC
C6   NC   NC
C7   NC   NC
C8   NC   NC
C9   GND   NC
D1   GND   NC
D10   NC   NC
D11   GND   NC
D12   NC   NC
D13   NC   NC
D14   NC   NC
D15   NC   NC
D16   GND   NC
D17   NC   NC
D18   NC   NC
D19   NC   NC
D2   NC   NC
D20   NC   NC
D21   GND   NC
D22   NC   NC
D23   NC   NC
D24   NC   NC
D25   NC   NC
D26   GND   NC
D27   NC   NC
D28   GND   NC
D29   NC   NC
D3   NC   NC
D30   NC   NC
D4   NC   NC
D5   NC   NC
D6   GND   NC
D7   NC   NC
D8   NC   NC
D9   NC   NC
E1   NC   NC
E10   NC   NC
E11   NC   NC
E12   NC   NC
E13   GND   NC
E14   NC   NC
E15   NC   NC
E16   NC   NC
E17   NC   NC
E18   GND   NC
E19   NC   NC
E2   NC   NC
E20   NC   NC
E21   NC   NC
E22   NC   NC
E23   GND   NC
E24   NC   NC
E25   NC   NC
E26   GND   NC
E27   GND   NC
E28   GND   NC
E29   GND   NC
E3   GND   NC
E30   GND   NC
E4   NC   NC
E5   NC   NC
E6   NC   NC
E7   NC   NC
E8   GND   NC
E9   NC   NC
F1   NC   NC
F10   GND   NC
F11   NC   NC
F12   GND   NC
F13   NC   NC
F14   GND   NC
F15   GND   NC
F16   GND   NC
F17   GND   NC
F18   GND   NC
F19   GND   NC
F2   NC   NC
F20   GND   NC
F21   GND   NC
F22   GND   NC
F23   NC   NC
F24   NC   NC
F25   GND   NC
F26   GND   NC
F27   NC   NC
F28   GND   NC
F29   NC   NC
F3   NC   NC
F30   NC   NC
F4   NC   NC
F5   GND   NC
F6   NC   NC
F7   NC   NC
F8   GND   NC
F9   NC   NC
G1   NC   NC
G10   NC   NC
G11   GND   NC
G12   NC   VCCIO_PIO_3A_T
G13   GND   NC
G14   NC   VCCIO_PIO_3A_B
G15   GND   NC
G16   GND   NC
G17   GND   NC
G18   GND   NC
G19   GND   NC
G2   GND   NC
G20   GND   NC
G21   GND   NC
G22   GND   NC
G23   GND   NC
G24   GND   NC
G25   GND   NC
G26   GND   NC
G27   NC   NC
G28   GND   NC
G29   GND   NC
G3   NC   NC
G30   GND   NC
G4   NC   NC
G5   NC   NC
G6   NC   NC
G7   GND   NC
G8   NC   NC
G9   GND   NC
H1   NC   NC
H10   GND   NC
H11   NC   VCCIO_PIO_3A_T
H12   GND   NC
H13   NC   VCCIO_PIO_3A_B
H14   GND   NC
H15   GND   NC
H16   GND   NC
H17   GND   NC
H18   GND   NC
H19   GND   NC
H2   NC   NC
H20   GND   NC
H21   GND   NC
H22   GND   NC
H23   GND   NC
H24   NC   NC
H25   NC   NC
H26   GND   NC
H27   GND   NC
H28   GND   NC
H29   NC   NC
H3   NC   NC
H30   NC   NC
H4   GND   NC
H5   NC   NC
H6   NC   NC
H7   NC   NC
H8   GND   NC
H9   NC   VCCPT_HVIO
J1   GND   NC
J10   NC   VCCP
J11   GND   NC
J12   NC   VCCP
J13   GND   NC
J14   NC   VCCP
J15   GND   NC
J16   GND   NC
J17   GND   NC
J18   GND   NC
J19   GND   NC
J2   NC   NC
J20   GND   NC
J21   GND   NC
J22   GND   NC
J23   GND   NC
J24   GND   NC
J25   GND   NC
J26   GND   NC
J27   NC   NC
J28   GND   NC
J29   GND   NC
J3   NC   NC
J30   GND   NC
J4   NC   NC
J5   NC   NC
J6   GND   NC
J7   NC   NC
J8   NC   VCCPT_HVIO
J9   GND   NC
K1   NC   NC
K10   GND   NC
K11   NC   VCCP
K12   GND   NC
K13   NC   VCCP
K14   GND   NC
K15   NC   VCCP
K16   GND   NC
K17   GND   NC
K18   GND   NC
K19   GND   NC
K2   NC   NC
K20   GND   NC
K21   GND   NC
K22   GND   NC
K23   GND   NC
K24   NC   NC
K25   NC   NC
K26   GND   NC
K27   NC   NC
K28   GND   NC
K29   NC   NC
K3   GND   NC
K30   NC   NC
K4   NC   NC
K5   NC   NC
K6   NC   NC
K7   NC   NC
K8   GND   NC
K9   NC   NC
L1   NC   NC
L10   NC   VCCPT
L11   GND   NC
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[Define Package Model]   ibs_A5E008_M16A_gpio
[Manufacturer]   name 1
[OEM]   name 2
[Description]   363-pin Package
|[Number of Sections]   1
[Number of Pins]   363
[Pin Numbers]
|[Pin Name]  Net Number   Net Name   Net's All Pins
M25   | 1   1A_REFCLK_1_N   M25
M24   | 2   1A_REFCLK_1_P   M24
K25   | 3   1A_REFCLK_2_N   K25
K24   | 4   1A_REFCLK_2_P   K24
P24   | 5   1A_REFCLK_N_CLKRX   P24
P25   | 6   1A_REFCLK_P_CLKRX   P25
K29   | 7   1A_RX_0_N   K29
K30   | 8   1A_RX_0_P   K30
H29   | 9   1A_RX_1_N   H29
H30   | 10   1A_RX_1_P   H30
F29   | 11   1A_RX_2_N   F29
F30   | 12   1A_RX_2_P   F30
D29   | 13   1A_RX_3_N   D29
D30   | 14   1A_RX_3_P   D30
P29   | 15   1A_TX_0_N   P29
P30   | 16   1A_TX_0_P   P30
M28   | 17   1A_TX_1_N   M28
M29   | 18   1A_TX_1_P   M29
J27   | 19   1A_TX_2_N   J27
K27   | 20   1A_TX_2_P   K27
F27   | 21   1A_TX_3_N   F27
G27   | 22   1A_TX_3_P   G27
H25   | 23   APROBE2_CH3_1A   H25
R27   | 24   APROBE_ATB_1A   R27
P27   | 25   APROBE_CH2_1A   P27
H24   | 26   APROBE_CH3_1A   H24
P7   | 27   D0_D0_2A_DQ0_N   P7
R7   | 28   D0_D0_2A_DQ0_P   R7
N7   | 29   D0_D0_2A_DQ1_N   N7
N6   | 30   D0_D0_2A_DQ1_P   N6
T7   | 31   D0_D0_2A_DQ2_N   T7
T6   | 32   D0_D0_2A_DQ2_P   T6
U6   | 33   D0_D0_2A_DQ4_N   U6
V5   | 34   D0_D0_2A_DQ4_P   V5
W5   | 35   D0_D0_2A_DQ5_N   W5
V6   | 36   D0_D0_2A_DQ5_P   V6
R6   | 37   D0_D0_2A_DQS3_N   R6
R5   | 38   D0_D0_2A_DQS3_P   R5
P3   | 39   D1_D0_2A_DQ6_N   P3
N3   | 40   D1_D0_2A_DQ6_P   N3
P4   | 41   D1_D0_2A_DQ7_N   P4
P5   | 42   D1_D0_2A_DQ7_P   P5
R4   | 43   D1_D0_2A_DQ8_N   R4
T3   | 44   D1_D0_2A_DQ8_P   T3
U3   | 45   D1_D0_2A_DQ10_N   U3
U4   | 46   D1_D0_2A_DQ10_P   U4
W3   | 47   D1_D0_2A_DQ11_N   W3
V3   | 48   D1_D0_2A_DQ11_P   V3
T4   | 49   D1_D0_2A_DQS9_N   T4
U5   | 50   D1_D0_2A_DQS9_P   U5
W7   | 51   D2_D1_2A_DQ12_N   W7
V7   | 52   D2_D1_2A_DQ12_P   V7
Y6   | 53   D2_D1_2A_DQ13_N   Y6
Y7   | 54   D2_D1_2A_DQ13_P   Y7
AA7   | 55   D2_D1_2A_DQ14_N   AA7
AA6   | 56   D2_D1_2A_DQ14_P   AA6
AD7   | 57   D2_D1_2A_DQ16_N   AD7
AC7   | 58   D2_D1_2A_DQ16_P   AC7
AC5   | 59   D2_D1_2A_DQ17_N   AC5
AC6   | 60   D2_D1_2A_DQ17_P   AC6
AB6   | 61   D2_D1_2A_DQS15_N   AB6
AB5   | 62   D2_D1_2A_DQS15_P   AB5
N1   | 63   D3_D1_2A_DQ18_N   N1
N2   | 64   D3_D1_2A_DQ18_P   N2
P2   | 65   D3_D1_2A_DQ19_N   P2
R1   | 66   D3_D1_2A_DQ19_P   R1
T1   | 67   D3_D1_2A_DQ20_N   T1
R2   | 68   D3_D1_2A_DQ20_P   R2
V2   | 69   D3_D1_2A_DQ22_N   V2
V1   | 70   D3_D1_2A_DQ22_P   V1
W2   | 71   D3_D1_2A_DQ23_N   W2
Y1   | 72   D3_D1_2A_DQ23_P   Y1
U1   | 73   D3_D1_2A_DQS21_N   U1
T2   | 74   D3_D1_2A_DQS21_P   T2
Y5   | 75   D4_D2_2A_DQ24_N   Y5
W4   | 76   D4_D2_2A_DQ24_P   W4
AA3   | 77   D4_D2_2A_DQ25_N   AA3
Y4   | 78   D4_D2_2A_DQ25_P   Y4
AA4   | 79   D4_D2_2A_DQ26_N   AA4
AB3   | 80   D4_D2_2A_DQ26_P   AB3
AD4   | 81   D4_D2_2A_DQ28_N   AD4
AD3   | 82   D4_D2_2A_DQ28_P   AD3
AE5   | 83   D4_D2_2A_DQ29_N   AE5
AD5   | 84   D4_D2_2A_DQ29_P   AD5
AC3   | 85   D4_D2_2A_DQS27_N   AC3
AB4   | 86   D4_D2_2A_DQS27_P   AB4
AE4   | 87   D5_D2_2A_DQ30_N   AE4
AF3   | 88   D5_D2_2A_DQ30_P   AF3
AG4   | 89   D5_D2_2A_DQ31_N   AG4
AF4   | 90   D5_D2_2A_DQ31_P   AF4
AG6   | 91   D5_D2_2A_DQ32_N   AG6
AH6   | 92   D5_D2_2A_DQ32_P   AH6
AE6   | 93   D5_D2_2A_DQ34_N   AE6
AF6   | 94   D5_D2_2A_DQ34_P   AF6
AE7   | 95   D5_D2_2A_DQ35_N   AE7
AF7   | 96   D5_D2_2A_DQ35_P   AF7
AG5   | 97   D5_D2_2A_DQS33_N   AG5
AH5   | 98   D5_D2_2A_DQS33_P   AH5
AF2   | 99   D6_D3_2A_DQ36_N   AF2
AG1   | 100   D6_D3_2A_DQ36_P   AG1
AE2   | 101   D6_D3_2A_DQ37_N   AE2
AF1   | 102   D6_D3_2A_DQ37_P   AF1
AE1   | 103   D6_D3_2A_DQ38_N   AE1
AD2   | 104   D6_D3_2A_DQ38_P   AD2
AA1   | 105   D6_D3_2A_DQ40_N   AA1
Y2   | 106   D6_D3_2A_DQ40_P   Y2
AA2   | 107   D6_D3_2A_DQ41_N   AA2
AB1   | 108   D6_D3_2A_DQ41_P   AB1
AC2   | 109   D6_D3_2A_DQS39_N   AC2
AC1   | 110   D6_D3_2A_DQS39_P   AC1
AJ7   | 111   D7_D3_2A_DQ42_N   AJ7
AK6   | 112   D7_D3_2A_DQ42_P   AK6
AJ8   | 113   D7_D3_2A_DQ43_N   AJ8
AK7   | 114   D7_D3_2A_DQ43_P   AK7
AK5   | 115   D7_D3_2A_DQ44_N   AK5
AJ5   | 116   D7_D3_2A_DQ44_P   AJ5
AG3   | 117   D7_D3_2A_DQ46_N   AG3
AH2   | 118   D7_D3_2A_DQ46_P   AH2
AH3   | 119   D7_D3_2A_DQ47_N   AH3
AJ3   | 120   D7_D3_2A_DQ47_P   AJ3
AJ4   | 121   D7_D3_2A_DQS45_N   AJ4
AK4   | 122   D7_D3_2A_DQS45_P   AK4
N5   | 123   D8_D4_3A_DQ48_N   N5
M5   | 124   D8_D4_3A_DQ48_P   M5
L6   | 125   D8_D4_3A_DQ49_N   L6
M6   | 126   D8_D4_3A_DQ49_P   M6
K6   | 127   D8_D4_3A_DQ50_N   K6
L7   | 128   D8_D4_3A_DQ50_P   L7
G5   | 129   D8_D4_3A_DQ52_N   G5
G6   | 130   D8_D4_3A_DQ52_P   G6
H6   | 131   D8_D4_3A_DQ53_N   H6
H7   | 132   D8_D4_3A_DQ53_P   H7
J7   | 133   D8_D4_3A_DQS51_N   J7
K7   | 134   D8_D4_3A_DQS51_P   K7
M4   | 135   D9_D4_3A_DQ54_N   M4
M3   | 136   D9_D4_3A_DQ54_P   M3
L4   | 137   D9_D4_3A_DQ55_N   L4
L3   | 138   D9_D4_3A_DQ55_P   L3
K4   | 139   D9_D4_3A_DQ56_N   K4
K5   | 140   D9_D4_3A_DQ56_P   K5
G4   | 141   D9_D4_3A_DQ58_N   G4
H3   | 142   D9_D4_3A_DQ58_P   H3
H5   | 143   D9_D4_3A_DQ59_N   H5
J5   | 144   D9_D4_3A_DQ59_P   J5
J3   | 145   D9_D4_3A_DQS57_N   J3
J4   | 146   D9_D4_3A_DQS57_P   J4
L1   | 147   D10_D5_3A_DQ60_N   L1
M1   | 148   D10_D5_3A_DQ60_P   M1
K1   | 149   D10_D5_3A_DQ61_N   K1
L2   | 150   D10_D5_3A_DQ61_P   L2
K2   | 151   D10_D5_3A_DQ62_N   K2
J2   | 152   D10_D5_3A_DQ62_P   J2
F1   | 153   D10_D5_3A_DQ64_N   F1
G1   | 154   D10_D5_3A_DQ64_P   G1
E1   | 155   D10_D5_3A_DQ65_N   E1
F2   | 156   D10_D5_3A_DQ65_P   F2
H1   | 157   D10_D5_3A_DQS63_N   H1
H2   | 158   D10_D5_3A_DQS63_P   H2
E2   | 159   D11_D5_3A_DQ66_N   E2
D2   | 160   D11_D5_3A_DQ66_P   D2
F3   | 161   D11_D5_3A_DQ67_N   F3
G3   | 162   D11_D5_3A_DQ67_P   G3
E4   | 163   D11_D5_3A_DQ68_N   E4
F4   | 164   D11_D5_3A_DQ68_P   F4
E6   | 165   D11_D5_3A_DQ70_N   E6
F6   | 166   D11_D5_3A_DQ70_P   F6
D4   | 167   D11_D5_3A_DQ71_N   D4
C5   | 168   D11_D5_3A_DQ71_P   C5
E5   | 169   D11_D5_3A_DQS69_N   E5
D5   | 170   D11_D5_3A_DQS69_P   D5
D8   | 171   D12_D6_3A_DQ72_N   D8
D7   | 172   D12_D6_3A_DQ72_P   D7
F7   | 173   D12_D6_3A_DQ73_N   F7
E7   | 174   D12_D6_3A_DQ73_P   E7
E10   | 175   D12_D6_3A_DQ74_N   E10
E9   | 176   D12_D6_3A_DQ74_P   E9
E15   | 177   D12_D6_3A_DQ76_N   E15
E14   | 178   D12_D6_3A_DQ76_P   E14
E12   | 179   D12_D6_3A_DQ77_N   E12
F13   | 180   D12_D6_3A_DQ77_P   F13
F11   | 181   D12_D6_3A_DQS75_N   F11
E11   | 182   D12_D6_3A_DQS75_P   E11
B6   | 183   D13_D6_3A_DQ78_N   B6
A7   | 184   D13_D6_3A_DQ78_P   A7
C6   | 185   D13_D6_3A_DQ79_N   C6
C7   | 186   D13_D6_3A_DQ79_P   C7
B4   | 187   D13_D6_3A_DQ80_N   B4
A4   | 188   D13_D6_3A_DQ80_P   A4
B3   | 189   D13_D6_3A_DQ82_N   B3
C3   | 190   D13_D6_3A_DQ82_P   C3
D3   | 191   D13_D6_3A_DQ83_N   D3
C2   | 192   D13_D6_3A_DQ83_P   C2
B5   | 193   D13_D6_3A_DQS81_N   B5
A6   | 194   D13_D6_3A_DQS81_P   A6
C13   | 195   D14_D7_3A_DQ84_N   C13
D14   | 196   D14_D7_3A_DQ84_P   D14
C15   | 197   D14_D7_3A_DQ85_N   C15
D15   | 198   D14_D7_3A_DQ85_P   D15
C12   | 199   D14_D7_3A_DQ86_N   C12
D13   | 200   D14_D7_3A_DQ86_P   D13
D9   | 201   D14_D7_3A_DQ88_N   D9
C8   | 202   D14_D7_3A_DQ88_P   C8
C10   | 203   D14_D7_3A_DQ89_N   C10
D10   | 204   D14_D7_3A_DQ89_P   D10
C11   | 205   D14_D7_3A_DQS87_N   C11
D12   | 206   D14_D7_3A_DQS87_P   D12
A13   | 207   D15_D7_3A_DQ90_N   A13
B13   | 208   D15_D7_3A_DQ90_P   B13
A14   | 209   D15_D7_3A_DQ91_N   A14
B14   | 210   D15_D7_3A_DQ91_P   B14
A12   | 211   D15_D7_3A_DQ92_N   A12
B11   | 212   D15_D7_3A_DQ92_P   B11
B8   | 213   D15_D7_3A_DQ94_N   B8
A8   | 214   D15_D7_3A_DQ94_P   A8
B9   | 215   D15_D7_3A_DQ95_N   B9
A9   | 216   D15_D7_3A_DQ95_P   A9
A11   | 217   D15_D7_3A_DQS93_N   A11
B10   | 218   D15_D7_3A_DQS93_P   B10
AH17   | 219   DTS_CALIB0   AH17
AH16   | 220   DTS_CALIB1   AH16
AH13   | 221   EDM_IN   AH13
AJ13   | 222   EDM_OUT   AJ13
B29   | 223   HPS_IOA_1   B29
A27   | 224   HPS_IOA_2   A27
C27   | 225   HPS_IOA_3   C27
F24   | 226   HPS_IOA_4   F24
B28   | 227   HPS_IOA_5   B28
F23   | 228   HPS_IOA_6   F23
D27   | 229   HPS_IOA_7   D27
E22   | 230   HPS_IOA_8   E22
C26   | 231   HPS_IOA_9   C26
D22   | 232   HPS_IOA_10   D22
A23   | 233   HPS_IOA_11   A23
A26   | 234   HPS_IOA_12   A26
D25   | 235   HPS_IOA_13   D25
B26   | 236   HPS_IOA_14   B26
B25   | 237   HPS_IOA_15   B25
E17   | 238   HPS_IOA_16   E17
A16   | 239   HPS_IOA_17   A16
E16   | 240   HPS_IOA_18   E16
D24   | 241   HPS_IOA_19   D24
E21   | 242   HPS_IOA_20   E21
B23   | 243   HPS_IOA_21   B23
D20   | 244   HPS_IOA_22   D20
B24   | 245   HPS_IOA_23   B24
A24   | 246   HPS_IOA_24   A24
D23   | 247   HPS_IOB_1   D23
C25   | 248   HPS_IOB_2   C25
A18   | 249   HPS_IOB_3   A18
C20   | 250   HPS_IOB_4   C20
A17   | 251   HPS_IOB_5   A17
C21   | 252   HPS_IOB_6   C21
C23   | 253   HPS_IOB_7   C23
E20   | 254   HPS_IOB_8   E20
C22   | 255   HPS_IOB_9   C22
D19   | 256   HPS_IOB_10   D19
B21   | 257   HPS_IOB_11   B21
A22   | 258   HPS_IOB_12   A22
B16   | 259   HPS_IOB_13   B16
B18   | 260   HPS_IOB_14   B18
E19   | 261   HPS_IOB_15   E19
B20   | 262   HPS_IOB_16   B20
C18   | 263   HPS_IOB_17   C18
A21   | 264   HPS_IOB_18   A21
D17   | 265   HPS_IOB_19   D17
A19   | 266   HPS_IOB_20   A19
D18   | 267   HPS_IOB_21   D18
B19   | 268   HPS_IOB_22   B19
C17   | 269   HPS_IOB_23   C17
C16   | 270   HPS_IOB_24   C16
E24   | 271   HPS_IO_OA_APROBE1   E24
E25   | 272   HPS_IO_OA_APROBE2   E25
AB24   | 273   HVIO_ATB0_X0Y0   AB24
AC10   | 274   HVIO_ATB0_X1Y0   AC10
G8   | 275   HVIO_ATB0_X1Y3   G8
AC25   | 276   HVIO_ATB1_X0Y0   AC25
AD9   | 277   HVIO_ATB1_X1Y0   AD9
F9   | 278   HVIO_ATB1_X1Y3   F9
AJ24   | 279   HVIO_B0_0_0_5A   AJ24
AJ23   | 280   HVIO_B0_0_1_5A   AJ23
AH21   | 281   HVIO_B0_0_2_5A   AH21
AJ19   | 282   HVIO_B0_0_3_5A   AJ19
AH23   | 283   HVIO_B0_1_0_5A   AH23
AH22   | 284   HVIO_B0_1_1_5A   AH22
AG23   | 285   HVIO_B0_1_2_5A   AG23
AH20   | 286   HVIO_B0_1_3_5A   AH20
AJ22   | 287   HVIO_B0_2_0_5A   AJ22
AJ20   | 288   HVIO_B0_2_1_5A   AJ20
AH18   | 289   HVIO_B0_2_2_5A   AH18
AG21   | 290   HVIO_B0_2_3_5A   AG21
AF24   | 291   HVIO_B0_3_0_5A   AF24
AG24   | 292   HVIO_B0_3_1_5A   AG24
AF23   | 293   HVIO_B0_3_2_5A   AF23
AG20   | 294   HVIO_B0_3_3_5A   AG20
AG19   | 295   HVIO_B0_4_0_5A   AG19
AF22   | 296   HVIO_B0_4_1_5A   AF22
AF19   | 297   HVIO_B0_4_2_5A   AF19
AF21   | 298   HVIO_B0_4_3_5A   AF21
AK24   | 299   HVIO_B1_0_0_5B   AK24
AH26   | 300   HVIO_B1_0_1_5B   AH26
AJ25   | 301   HVIO_B1_0_2_5B   AJ25
AH25   | 302   HVIO_B1_0_3_5B   AH25
AG26   | 303   HVIO_B1_1_0_5B   AG26
AE25   | 304   HVIO_B1_1_1_5B   AE25
AK25   | 305   HVIO_B1_1_2_5B   AK25
AF26   | 306   HVIO_B1_1_3_5B   AF26
AJ27   | 307   HVIO_B1_2_0_5B   AJ27
AH27   | 308   HVIO_B1_2_1_5B   AH27
AK19   | 309   HVIO_B1_2_2_5B   AK19
AK22   | 310   HVIO_B1_2_3_5B   AK22
AJ29   | 311   HVIO_B1_3_0_5B   AJ29
AK26   | 312   HVIO_B1_3_1_5B   AK26
AH28   | 313   HVIO_B1_3_2_5B   AH28
AK20   | 314   HVIO_B1_3_3_5B   AK20
AF27   | 315   HVIO_B1_4_0_5B   AF27
AJ28   | 316   HVIO_B1_4_1_5B   AJ28
AK21   | 317   HVIO_B1_4_2_5B   AK21
AK27   | 318   HVIO_B1_4_3_5B   AK27
AC23   | 319   HVIO_VIEWPIN0_X0Y0   AC23
AC8   | 320   HVIO_VIEWPIN0_X1Y0   AC8
U8   | 321   HVIO_VIEWPIN0_X1Y1   U8
L8   | 322   HVIO_VIEWPIN0_X1Y2   L8
K9   | 323   HVIO_VIEWPIN0_X1Y3   K9
AJ10   | 324   I2C_PWRMGT_SCL   AJ10
AG9   | 325   I2C_PWRMGT_SDA   AG9
AG15   | 326   NRST__NCONFIG   AG15
AG11   | 327   OSC_CLK_1   AG11
AH15   | 328   POR_BYPASS   AH15
AF11   | 329   PWRMGT_ALERT   AF11
AH10   | 330   QSPI_CLK__SDMMC_DATA0   AH10
AE10   | 331   QSPI_IO0__SDMMC_CMD   AE10
AK9   | 332   QSPI_IO1__SDMMC_DATA1   AK9
AF14   | 333   QSPI_IO2_WPN__SDMMC_DATA2   AF14
AG14   | 334   QSPI_IO3_HOLD__SDMMC_DATA3   AG14
AH12   | 335   QSPI_SS0__SDMMC_CCLK   AH12
AJ9   | 336   QSPI_SS1__SDMMC_PWR_ENA   AJ9
AK10   | 337   QSPI_SS2   AK10
AF13   | 338   QSPI_SS3__SDMMC_DATA4   AF13
T25   | 339   RCOMP_N_CH1_1A   T25
T24   | 340   RCOMP_P_CH1_1A   T24
AK12   | 341   REXT   AK12
AF12   | 342   SDMMC_DATA5   AF12
AG13   | 343   SDMMC_DATA6   AG13
AH11   | 344   SDMMC_DATA7   AH11
AG16   | 345   STATUS0__NSTATUS   AG16
AF9   | 346   STATUS1__CONF_DONE   AF9
AG10   | 347   STATUS2__INIT_DONE   AG10
AJ17   | 348   TBGREF   AJ17
AF16   | 349   TCK   AF16
AE17   | 350   TDI   AE17
AE16   | 351   TDO   AE16
AJ12   | 352   TMD_DIODEH   AJ12
AK11   | 353   TMD_DIODEL   AK11
AF17   | 354   TMS   AF17
AJ18   | 355   TPWELL0   AJ18
AE12   | 356   VIEWPIN_2A   AE12
G10   | 357   VIEWPIN_3A   G10
AK15   | 358   VREFN   AK15
AJ15   | 359   VREFP   AJ15
AJ14   | 360   VSIGN_0   AJ14
AK16   | 361   VSIGN_1   AK16
AK14   | 362   VSIGP_0   AK14
AK17   | 363   VSIGP_1   AK17
[Model Data]
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[End Model Data]
[End Package Model]
| Models and submodels in the file (5): dsstl12_in_e0g50 (Input), lv12_in (Input), lv12_in_wpu (Input), lv12_io_us0r34 (I/O), lv33_in (Input)
